ADE simulation setup
Test wk_ADPLL:DCCS:1: wk_ADPLL/DCCS/schematic, simulator spectre
  Models: $SPECTRE_MODEL_PATH/design_wrapper.lib.scs[tt_pre]
  Variables: R = 1K; Wref = 2u; H = 0.8; L = 0; s1 = L; s2 = L
  Temperature: 27
  Simulator options: additionalArgs=vdsatmod=gds
  Stimulus VSS: voltage dc dc=0
  Stimulus VDD: voltage dc dc=0.8
  Stimulus Vs2: voltage dc dc=s2
  Stimulus Vs1: voltage dc dc=s1
  Stimulus Vs3: voltage dc dc=s3
  Analysis dc: (saves the operating point)
  Analysis tran: stop=2n errpreset=moderate outputstart=0.2n
  Output avgIref = average(IT("/R0/PLUS"))
  Output diffAvgIref = (ymax(avgIref ?overall t) - ymin(avgIref ?overall t))
  Output avgVref = average(VT("/Iref"))
  Signals: /R0/PLUS (terminal), /Iref
Test T1: wk_ADPLL/DCCS/schematic, simulator spectre
  Models: $SPECTRE_MODEL_PATH/design_wrapper.lib.scs[tt_pre]
  Variables: R = 1K; Wref = 2u; H = 0.8; L = 0; s1 = L; s2 = L
  Temperature: 27
  Simulator options: additionalArgs=vdsatmod=gds
  Stimulus VSS: voltage dc dc=0
  Stimulus VDD: voltage dc dc=0.8
  Stimulus Vs2: voltage dc dc=s2
  Stimulus Vs1: voltage dc dc=s1
  Stimulus Vs3: voltage dc dc=s3
  Stimulus Vs4: voltage dc dc=s4
  Analysis dc: (saves the operating point)
  Analysis tran: stop=2n errpreset=moderate outputstart=0.2n
  Output avgIref = average(IT("/R0/PLUS"))
  Output CornerDiffAvgIref = (ymax(avgIref ?overall t) - ymin(avgIref ?overall t))
  Output avgVref = average(VT("/Iref"))
  Output CornerAvgIref = average(avgIref ?overall t)
  Output CornerDiffAvgIrefPercent = (100 * (CornerDiffAvgIref / CornerAvgIref))
  Output average(IT("/N37/d"))
  Signals: /R0/PLUS (terminal), /Iref, /N37/d (terminal) as Igen
