ADE simulation setup
Run mode: Single Run, Sweeps and Corners
Tests:
  wk_ADPLL:DCCS:1: wk_ADPLL/DCCS/schematic, simulator spectre
    Variables: H = 0.8; L = 0; s1 = L; s2 = L; Wref = 2u; R = 1K
    Outputs: average(VT("/R0/PLUS)")); average(Iref); average(VT("/Iref")) [A]; avgIref; /Vs1; /Vs2; /N0/d; /Iref; diffAvgIref; avgVref
Global variables:
  s1 = L
  s2 = H
  s3 = H
  Wref = 1u
  R = 50
  M1 = 1
  I = 1.3m
  M2 = 2
  M3 = 4
  NFup = 7
  Lmrr = 20n 40n 80n 120n
  Lsw = 20n
Corners (nominal off):
  model folders: $SPECTRE_MODEL_PATH
  TT_85 (off): temperature=85; design_wrapper_mmw.lib.scs[tt_pre]
  TT_125 (off): temperature=125; design_wrapper_mmw.lib.scs[tt_pre]
  SS_m40 (off): temperature=-40; design_wrapper_mmw.lib.scs[ss_pre]
  SS_125: temperature=125; design_wrapper_mmw.lib.scs[ss_pre]
  FF_m40: temperature=-40; design_wrapper_mmw.lib.scs[ff_pre]
  FF_125 (off): temperature=125; design_wrapper_mmw.lib.scs[ff_pre]
