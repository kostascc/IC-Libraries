ADE simulation setup
Run mode: Single Run, Sweeps and Corners
Tests:
  T1: wk_ADPLL/DCCS/schematic, simulator spectre
    Variables: H = 0.8; L = 0; s1 = L; s2 = L; Wref = 2u; R = 1K
    Outputs: average(VT("/R0/PLUS)")); average(Iref); average(VT("/Iref")) [A]; avgIref [A]; /Vs1; /Vs2; /N0/d; /Iref; CornerDiffAvgIref [A]; avgVref [V]; CornerAvgIref; CornerDiffAvgIrefPercent [%]
Global variables:
  s1 = H L H
  s2 = H L L
  s3 = H L L
  s4 = H H L
  Wref = 1u
  R = 200
  I = 600u
  Mref = 2
  Lref = 40n
  NFref = 8
  NFmrr1 = 4
  NFmrr2 = 8
  NFmrr3 = 16
  NFmrr4 = 32
  NFsw1 = NFmrr1
  NFsw2 = NFmrr2
  NFsw3 = NFmrr3
  NFsw4 = NFmrr4
  Lsw = 20n
  Lmrr = 20n
  Msw1 = 1
  Msw2 = 1
  Msw3 = 1
  Msw4 = 1
  Mmrr1 = 1
  Mmrr2 = 1
  Mmrr3 = 1
  Mmrr4 = 1
Corners (nominal off):
  model folders: $SPECTRE_MODEL_PATH
  TT_85 (off): temperature=85; design_wrapper_mmw.lib.scs[tt_pre]
  TT_125 (off): temperature=125; design_wrapper_mmw.lib.scs[tt_pre]
  SS_m40 (off): temperature=-40; design_wrapper_mmw.lib.scs[ss_pre]
  SS_125: temperature=125; design_wrapper_mmw.lib.scs[ss_pre]
  FF_m40: temperature=-40; design_wrapper_mmw.lib.scs[ff_pre]
  FF_125 (off): temperature=125; design_wrapper_mmw.lib.scs[ff_pre]
Specs:
  T1 / CornerDiffAvgIrefPercent: < 15
