ADE simulation setup
Test Steady_State: wk_ADPLL/VCO_LowNoise_56G/schematic, simulator spectre
  Models: $SPECTRE_MODEL_PATH/design_wrapper_mmw.lib.scs[tt_pre]
  Variables: M1 = 2; Wss = 150n; C = 1; I = 2m; NA = 0; W1 = 13u; Ws = 200n; Ws1 = 1*Ws; Ws2 = 2*Ws; Ws3 = 4*Ws; Ws4 = 8*Ws; Ws5 = 16*Ws; Ws6 = 32*Ws
  Temperature: 27
  Simulator options: additionalArgs=vdsatmod=gds
  Analysis tran: stop=6n errpreset=moderate noisefmax=300G outputstart=0.5n
  Output freqVop = freq(VT("/Vop") "rising" ?xName "time" ?mode "auto" ?threshold 0.8)
  Output avgFreqVop = average(freqVop)
  Output diffAvgFreqVop = (ymax(avgFreqVop ?overall t) - ymin(avgFreqVop ?overall t))
  Output avgCornerFreqVop = average(freqVop ?overall t)
  Output VppVop = peakToPeak(VT("/Vop"))
  Output diffFreqVop = (ymax(freqVop) - ymin(freqVop))
  Output OutNoise = rfOutputNoise("dBc/Hz" ?result "pnoise")
  Output PhaseNoise_1M = value(OutNoise 1000000.0)
  Output PhaseNoise_10M = value(OutNoise 1e+07)
  Signals: /Vop, /Vref
Test SS: wk_ADPLL/VCO_LowNoise_56G/schematic, simulator spectre
  Models: $SPECTRE_MODEL_PATH/design_wrapper_mmw.lib.scs[tt_pre]
  Variables: Lref = 20n; C1 = 470f; Lind = 350p; L1 = 200p; M1 = 2; Wss = 150n; C = 1; I = 2m; NA = 0; W1 = 13u
  Temperature: 27
  Simulator options: additionalArgs=vdsatmod=gds
  Analysis tran: stop=6n errpreset=moderate noisefmax=300G outputstart=0.5n
  Output freqVop = freq(VT("/Vop") "rising" ?xName "time" ?mode "auto" ?threshold 0.8)
  Output avgFreqVop = average(freqVop)
  Output diffAvgFreqVop = (ymax(avgFreqVop ?overall t) - ymin(avgFreqVop ?overall t))
  Output avgCornerFreqVop = average(freqVop ?overall t)
  Output VppVop = peakToPeak(VT("/Vop"))
  Output diffFreqVop = (ymax(freqVop) - ymin(freqVop))
  Output OutNoise = rfOutputNoise("dBc/Hz" ?result "pnoise")
  Output PhaseNoise_1M = value(OutNoise 1000000.0)
  Output PhaseNoise_10M = value(OutNoise 1e+07)
  Signals: /Vop as Vop, /Von as Von, /Vref, /N7/d (terminal)
