ADE simulation setup
Test Steady_State: wk_ADPLL/VCO_LowNoise_56G/schematic, simulator spectre
  Models: $SPECTRE_MODEL_PATH/design_wrapper_mmw.lib.scs[tt_pre]
  Variables: M1 = 2; Wss = 150n; C = 1; I = 2m; NA = 0; W1 = 13u; Ws = 200n; Ws1 = 1*Ws; Ws2 = 2*Ws; Ws3 = 4*Ws; Ws4 = 8*Ws; Ws5 = 16*Ws; Ws6 = 32*Ws
  Temperature: 27
  Simulator options: additionalArgs=vdsatmod=gds
  Stimulus S1: voltage dc dc=S1
  Stimulus Vsw6: voltage dc dc=B6
  Stimulus Vsw5: voltage dc dc=B5
  Stimulus Vsw4: voltage dc dc=B4
  Stimulus Vsw3: voltage dc dc=B3
  Stimulus Vsw2: voltage dc dc=B2
  Stimulus Vsw1: voltage dc dc=B1
  Stimulus Vbb: voltage dc dc=Vbb
  Stimulus Vb: voltage dc dc=Vb
  Stimulus Vbbb: voltage dc dc=Vbbb
  Initial conditions: /Va2 = 0.8; /Va1 = 0.8
  Analysis tran: stop=6n errpreset=moderate noisefmax=300G outputstart=0.5n
  Output freqVop = freq(VT("/Vop") "rising" ?xName "time" ?mode "auto" ?threshold 0.8)
  Output avgCornerFreqVop = average(freqVop ?overall t)
  Output diffAvgFreqVop = (ymax(avgFreqVop ?overall t) - ymin(avgFreqVop ?overall t))
  Output VppVa1 = peakToPeak(VT("/Vop"))
  Output diffFreqVa1 = (ymax(freqVop) - ymin(freqVop))
  Output OutNoise = rfOutputNoise("dBc/Hz" ?result "pnoise")
  Output PhaseNoise_1M = value(OutNoise 1000000.0)
  Output PhaseNoise_10M = value(OutNoise 1e+07)
  Output avgFreqVop = average(freqVop)
  Signals: /Vref
Run mode: Single Run, Sweeps and Corners
Global variables:
  Ws = 270n
  W1 = 30
  M1 = 1
  S1 = L
  Ms = 8
  C = 100
  I = 1.1m:0.4m:2.7m
  Wss = L (off)
  Vb = H
  B3 = L
  B1 = L
  B2 = L
  B4 = L
  B6 = L
  B5 = L
  H = 0.8
  L = 0
  Vbbb = 0.8
  Vbb = 0.8
  W2 = 1
  W3 = 4
  Ls = 20n
  L1 = 20n
  Lref = 20n
Device parameters (all switched off):
  wk_ADPLL/VCO_VI/schematic/N0.w = 13u 15u (off)
Corners (all switched off):
  model folders: $SPECTRE_MODEL_PATH
  TT_85: temperature=85; design_wrapper_mmw.lib.scs[tt_pre]
  TT_125 (off): temperature=125; design_wrapper_mmw.lib.scs[tt_pre]
  SS_m40: temperature=-40; design_wrapper_mmw.lib.scs[ss_pre]
  SS_125: temperature=125; design_wrapper_mmw.lib.scs[ss_pre]
  FF_m40: temperature=-40; design_wrapper_mmw.lib.scs[ff_pre]
  FF_125: temperature=125; design_wrapper_mmw.lib.scs[ff_pre]
Specs:
  Steady_State / diffAvgFreqVop: min 4G
  Steady_State / VppVa1: range 0.4 to 1.2
  Steady_State / diffFreqVa1: range 0 to 100M
  Steady_State / PhaseNoise_1M: < -90
  Steady_State / PhaseNoise_10M: < -110
  Steady_State / avgCornerFreqVop: range 46G to 66G
Disabled tests: Time_Sweep, wk_ADPLL:VCO_VI:1, wk_ADPLL:VCO_VI:2
