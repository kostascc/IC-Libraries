ADE simulation setup
Run mode: Single Run, Sweeps and Corners
Tests:
  SS: wk_ADPLL/VCO_LowNoise_56G/schematic, simulator spectre
    Variables: L1 = 200p; M1 = 2; Wss = 150n; C = 1; I = 2m; NA = 0; W1 = 13u; Lind = 350p; C1 = 470f; Lref = 20n
    Outputs: "/Vop"; "/Von"; freq(VT("/Va1") "rising" ?xName "time" ?mode "auto" ?threshold 0.6); average(freq(VT("/Va1") "rising" ?xName "time" ?mode "auto" ?threshold 0.8)); freqVop; average(VT("/freqVa1")); avgCornerFreqVop; ymax(?overall t); diffAvgFreqVop; VppVop; diffFreqVop; OutNoise [dBc/Hz]; PhaseNoise_1M [dBc/Hz]; PhaseNoise_10M [dBc/Hz]; avgFreqVop; /Vref; Vop; Von; /N6/d; /N7/d
Global variables:
  Ws = 270n
  W1 = 20 30 40
  M1 = 1 2 4
  C = 600f
  I = 2m:2m:16m
  H = 0.8
  L = 0
  Lind = 330p
  L1 = 120p
  L2 = 70p
Device parameters (all switched off):
  wk_ADPLL/VCO_VI/schematic/N0.w = 13u 15u (off)
Corners (all switched off):
  model folders: $SPECTRE_MODEL_PATH
  TT_85: temperature=85; design_wrapper_mmw.lib.scs[tt_pre]
  TT_125 (off): temperature=125; design_wrapper_mmw.lib.scs[tt_pre]
  SS_m40: temperature=-40; design_wrapper_mmw.lib.scs[ss_pre]
  SS_125: temperature=125; design_wrapper_mmw.lib.scs[ss_pre]
  FF_m40: temperature=-40; design_wrapper_mmw.lib.scs[ff_pre]
  FF_125: temperature=125; design_wrapper_mmw.lib.scs[ff_pre]
Specs:
  SS / diffAvgFreqVop: min 4G
  SS / VppVop: range 0.4 to 1.2
  SS / diffFreqVop: range 0 to 100M
  SS / PhaseNoise_1M: < -90
  SS / PhaseNoise_10M: < -110
  SS / avgCornerFreqVop: range 46G to 66G
