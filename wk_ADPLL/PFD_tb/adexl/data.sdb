ADE simulation setup
Run mode: Single Run, Sweeps and Corners
Tests:
  wk_ADPLL:PFD_tb:1: wk_ADPLL/PFD_tb/schematic, simulator spectre
Global variables:
  DTa = 0
  DTb = 0
  freqGEN = 28G
  freqREF = 28.4G
  tf = 0.08
  tr = 0.08
  VDD = 0.8
  VSS = 0
  Wn1 = 1.3u
  Wn3 = 5u
  Wni1 = 580n
  Wni2 = 580n
  Wp1 = 0.7u
  Wpi1 = 970n
  Wpi2 = 970n
  CL = 3f
  Wn2 = 1.3u
