ADE simulation setup
Run mode: Single Run, Sweeps and Corners
Tests:
  dt_sweep: wk_ADPLL/PFD_line_tb/schematic, simulator spectre
  minimal_dt_optimization (off): wk_ADPLL/PFD_line_tb/schematic, simulator spectre
Global variables:
  DTb = 0
  DTa = 0
  freqA = 28G
  freqB = 28.3G
  tf = 0.08
  tr = 0.08
  VDD = 800m
  VSS = 0
  CL = 3f
  Wp = 100n
  Wn = 100n
  N = 3
  Wpi2 = 970n
  Wpi1 = 970n
  Wni2 = 580n
  Wni1 = 580n
  Wp1 = 2.4u
  Wn3 = 2u
  Wn2 = 2u
  Wn1 = 2u
  va = 2.8
  vb = 1
  vc = 1
  vd = 1
