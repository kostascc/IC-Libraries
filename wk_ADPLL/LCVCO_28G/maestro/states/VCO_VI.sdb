ADE simulation setup
Run mode: Single Run, Sweeps and Corners
Tests:
  Steady_State: wk_ADPLL/VCO_VI/schematic, simulator spectre
    Variables: I = 2m; NA = 0; W1 = 13u; Ws1 = 1*Ws; Ws2 = 2*Ws; Ws3 = 4*Ws; Ws4 = 8*Ws; Ws5 = 16*Ws; Ws6 = 32*Ws; Ws = 200n; C = 1; Wss = 150n
    Outputs: /Va1; /Va2; freq(VT("/Va1") "rising" ?xName "time" ?mode "auto" ?threshold 0.6); average(freq(VT("/Va1") "rising" ?xName "time" ?mode "auto" ?threshold 0.8)); freqVa1; average(VT("/freqVa1")); avgFreqVa1; ymax(?overall t); diffAvgFreqVa1; VppVa1; diffFreqVa1; OutNoise [dBc/Hz]; PhaseNoise_1M [dBc/Hz]; PhaseNoise_10M [dBc/Hz]
  wk_ADPLL:VCO_VI:2 (off): wk_ADPLL/VCO_VI/schematic, simulator spectre
Global variables:
  Ws = 300n 200n
  W1 = 13u
  C = 23
  I = 2.8m
  Wss = 150n
  S1 = H
  B1 = L H
  B2 = L H
  B3 = L H
  B4 = L H
  B5 = L H
  B6 = L H
  H = 0.8
  L = 0
Device parameters (all switched off):
  wk_ADPLL/VCO_VI/schematic/N0.w = 13u 15u (off)
Corners (nominal off):
  model folders: $SPECTRE_MODEL_PATH
  NOM_85 (off): temperature=85; design_wrapper_mmw.lib.scs[tt_pre]
  SS_m40: temperature=-40; design_wrapper_mmw.lib.scs[ss_pre]
  SS_110: temperature=110; design_wrapper_mmw.lib.scs[ss_pre]
  FF_m40: temperature=-40; design_wrapper_mmw.lib.scs[ff_pre]
  FF_110: temperature=110; design_wrapper_mmw.lib.scs[ff_pre]
Specs:
  Steady_State / diffAvgFreqVa1: min 1
  Steady_State / VppVa1: range 0.4 to 1.2
  Steady_State / diffFreqVa1: range 0 to 70M
