ADE simulation setup
Run mode: Single Run, Sweeps and Corners
Tests:
  Steady_State: wk_ADPLL/LCVCO_28G/schematic, simulator spectre
    Variables: Cb = 2f; Cfb = 2f; Rb = 30; M1 = 2; Wss = 150n; C = 1; I = 2m; NA = 0; W1 = 13u; Ws = 200n; Ws1 = 1*Ws; Ws2 = 2*Ws; Ws3 = 4*Ws; Ws4 = 8*Ws; Ws5 = 16*Ws; Ws6 = 32*Ws
    Outputs: "/Vop"; "/Von"; freq(VT("/Va1") "rising" ?xName "time" ?mode "auto" ?threshold 0.6); average(freq(VT("/Va1") "rising" ?xName "time" ?mode "auto" ?threshold 0.8)); freqVo [Hz]; average(VT("/freqVa1")); avgCornerFreqVo [Hz]; ymax(?overall t); diffAvgFreqVo [Hz]; VppVo [V]; diffFreqVo [Hz]; OutNoise [dBc/Hz]; PhaseNoise_1M [dBc/Hz]; PhaseNoise_10M [dBc/Hz]; avgFreqVo [Hz]; /Vref; /Vop; /Von; VT("/Vop"); Vo [V]; VrefPeak [V]
Global variables:
  Ws = 270n
  W1 = 24
  C = 60
  M1 = 1
  I = 0.4m 0.6m
  S1 = L
  Ms = 8
  Vb = H
  Wss = L (off)
  B3 = L
  B1 = L
  B2 = L
  B4 = L
  B6 = L
  B5 = L
  H = 0.8
  L = 0
  Vbbb = 0.8
  Vbb = 0.8
  W2 = 1
  W3 = 4
  Ls = 20n
  L1 = 20n
  Lref = 35n
  Cfb = 2f
  Cb = 2f
  Rb = 4
  LT = 118p
  NFref = 30
Device parameters (all switched off):
  wk_ADPLL/VCO_VI/schematic/N0.w = 13u 15u (off)
Corners (nominal off):
  model folders: $SPECTRE_MODEL_PATH
  TT_50 (off): temperature=50; design_wrapper_mmw.lib.scs[tt_pre]
  TT_27 (off): temperature=27; design_wrapper_mmw.lib.scs[tt_pre]
  SS_0 (off): temperature=0; design_wrapper_mmw.lib.scs[ss_pre]
  SS_85: temperature=85; design_wrapper_mmw.lib.scs[ss_pre]
  FF_0: temperature=0; design_wrapper_mmw.lib.scs[ff_pre]
  FF_85 (off): temperature=85; design_wrapper_mmw.lib.scs[ff_pre]
Specs:
  Steady_State / diffAvgFreqVo: min 4G
  Steady_State / VppVo: range 0.4 to 1.2
  Steady_State / diffFreqVo: range 0 to 100M
  Steady_State / PhaseNoise_1M: < -90
  Steady_State / PhaseNoise_10M: < -110
  Steady_State / avgCornerFreqVo: range 18G to 38G
