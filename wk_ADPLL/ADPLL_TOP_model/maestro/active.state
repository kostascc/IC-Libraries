ADE simulation setup
Test wk_ADPLL:ADPLL_TOP_model:1: wk_ADPLL/ADPLL_TOP_model/schematic, simulator spectre
  Models: $SPECTRE_MODEL_PATH/design_wrapper.lib.scs[tt_pre]
  Variables: wireopt = 19
  Temperature: 27
  Simulator options: additionalArgs=vdsatmod=gds
  Analysis tran: stop=VAR("T_STOP")
  Analysis pss: engine=Harmonic Balance fund=28G harms=7 oscana=t p=/vco_out n=/vss
  Output freq(VT("/vco_out") "rising" ?xName "time" ?mode "auto" ?threshold 0.45)
  Output average(freq(VT("/vco_out") "rising" ?xName "time" ?mode "auto" ?threshold 0.45))
  Signals: /fref, /pfd_outp, /fdiv_out, /vco_out, /lpf_out
Run mode: Single Run, Sweeps and Corners
Global variables:
  wireopt = 19
  T_STOP = 5u
  MODE = 1
  fref = MODE*40M
  fmin = 26.5e9
  fmax = 29e9
  vdd = 0.9
  vss = 0
  FDIV_N = 800/MODE
Corners (nominal off):
  model folders: $SPECTRE_MODEL_PATH
  NOM_85: temperature=85; design_wrapper_mmw.lib.scs[tt_pre]
  SLOW_m40 (off): temperature=-40; design_wrapper_mmw.lib.scs[ss_pre]
  SLOW_125 (off): temperature=125; design_wrapper_mmw.lib.scs[ss_pre]
  FAST_m40 (off): temperature=-40; design_wrapper_mmw.lib.scs[ff_pre]
  FAST_125 (off): temperature=125; design_wrapper_mmw.lib.scs[ff_pre]
