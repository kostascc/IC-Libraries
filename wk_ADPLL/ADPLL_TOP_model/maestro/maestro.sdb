ADE simulation setup
Run mode: Single Run, Sweeps and Corners
Tests:
  wk_ADPLL:ADPLL_TOP_model:1: wk_ADPLL/ADPLL_TOP_model/config_schematic, simulator spectre
    Variables: wireopt = 19
Global variables:
  wireopt = 19
  T_STOP = 5u
  MODE = 1
  fref = MODE*40M
  fmin = 26.5e9
  fmax = 29e9
  vdd = 0.9
  vss = 0
  FDIV_N = 800/MODE
Corners (nominal off):
  model folders: $SPECTRE_MODEL_PATH
  NOM_85: temperature=85; design_wrapper_mmw.lib.scs[tt_pre]
  SLOW_m40 (off): temperature=-40; design_wrapper_mmw.lib.scs[ss_pre]
  SLOW_125 (off): temperature=125; design_wrapper_mmw.lib.scs[ss_pre]
  FAST_m40 (off): temperature=-40; design_wrapper_mmw.lib.scs[ff_pre]
  FAST_125 (off): temperature=125; design_wrapper_mmw.lib.scs[ff_pre]
