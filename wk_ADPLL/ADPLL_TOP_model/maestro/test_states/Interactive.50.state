ADE simulation setup
Test wk_ADPLL:ADPLL_TOP_model:1: wk_ADPLL/ADPLL_TOP_model/config_schematic, simulator spectre
  Models: $SPECTRE_MODEL_PATH/design_wrapper.lib.scs[tt_pre]
  Variables: wireopt = 19
  Temperature: 27
  Simulator options: additionalArgs=vdsatmod=gds
  Analysis tran: stop=VAR("T_STOP")
  Analysis pss: engine=Harmonic Balance fund=28G harms=7 oscana=t p=/vco_out n=/vss
  Output freq(VT("/vco_out") "rising" ?xName "time" ?mode "auto" ?threshold 0.45)
  Output average(freq(VT("/vco_out") "rising" ?xName "time" ?mode "auto" ?threshold 0.45))
  Signals: /fref, /pfd_outp, /fdiv_out, /vco_out, /lpf_out
