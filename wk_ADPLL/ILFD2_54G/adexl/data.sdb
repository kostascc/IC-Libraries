ADE simulation setup
Run mode: Single Run, Sweeps and Corners
Tests:
  wk_ADPLL:ILFD2_54G:2: wk_ADPLL/ILFD2_54G/schematic, simulator spectre
    Outputs: average(freq(VT("/Vdivp") "rising" ?xName "time" ?mode "auto" ?threshold 0.4)); /I17/MINUS; /Va1; /Va2; nil; /Vb1; /Vb2; AVGFa; Fa; Fb; AVGFb; "/Vsw1"; /AA; /BB; /Vsw1; /Vsw2; /Vsw3; /Vsw4; /Vsw5; /Vsw6; PRIM; /K0/s1
Global variables:
  C = 46.5f (off)
  F = 110G (off)
  I = 3.2m
  L = 65p (off)
  Q = 50 (off)
  Wn = 2.5u (off)
  Wp = 1u (off)
  freqOUT = 10G (off)
  tf = 0.08 (off)
  tr = 0.08 (off)
  C1 = 25f
  C2 = 30f
  F1 = 56G
  F2 = 28G
  L1 = 220p
  L2 = 210p
  W1 = 12u
  W2 = 15u
  Ws1 = 1*Ws
  Ws2 = 2*Ws
  Ws3 = 4*Ws
  Ws4 = 8*Ws
  Ws5 = 16*Ws
  Ws6 = 32*Ws
  Ws = 0.3u
Corners:
  model folders: $SPECTRE_MODEL_PATH
  FF_PRE (off): design_wrapper.lib.scs[ff_pre]
  FS_PRE (off): design_wrapper.lib.scs[fs_pre]
  SF_PRE (off): design_wrapper.lib.scs[sf_pre]
  SS_PRE (off): design_wrapper.lib.scs[ff_pre]
  FF_POST (off): design_wrapper.lib.scs[ff_post]
  FS_POST (off): design_wrapper.lib.scs[fs_post]
  SF_POST (off): design_wrapper.lib.scs[sf_post]
  SS_POST (off): design_wrapper.lib.scs[ff_post]
