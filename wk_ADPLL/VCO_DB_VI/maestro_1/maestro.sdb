ADE simulation setup
Run mode: Single Run, Sweeps and Corners
Tests:
  wk_ADPLL:ILFD2_54G:1: wk_ADPLL/ILFD2_54G/schematic, simulator spectre
    Variables: C2 = 0; I = 3.1m; W1 = 15u; Ws4 = 4*Ws; Ws1 = 1*Ws; Ws2 = 2*Ws; Ws3 = 3*Ws; Ws5 = 5*Ws; Ws6 = 6*Ws; Ws = 0.4u; I2 = 4.1m; I1 = 6.1m; W2 = 11u; Wn = 0.97u; Wp = 0.58u
    Outputs: "/Va1"; "/Va2"; Iscd; Iprm; freq(VT("/Va1") "rising" 0.8); freq(VT("/Va1") "rising" ?xName "time" ?mode "auto" ?threshold 0.6); /Vsw1; /Vsw2; /Vb1; /Vb2
Global variables:
  I1 = 20m
  I2 = 0.005m
Corners (all switched off):
  model folders: $SPECTRE_MODEL_PATH
  NOM_85: temperature=85; design_wrapper_mmw.lib.scs[tt_pre]
  SLOW_m40 (off): temperature=-40; design_wrapper_mmw.lib.scs[ss_pre]
  SLOW_125 (off): temperature=125; design_wrapper_mmw.lib.scs[ss_pre]
  FAST_m40 (off): temperature=-40; design_wrapper_mmw.lib.scs[ff_pre]
  FAST_125 (off): temperature=125; design_wrapper_mmw.lib.scs[ff_pre]
