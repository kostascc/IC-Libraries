ADE simulation setup
Test wk_ADPLL:ILFD2_54G:1: wk_ADPLL/ILFD2_54G/schematic, simulator spectre
  Models: $SPECTRE_MODEL_PATH/design_wrapper_mmw.lib.scs[tt_pre]
  Variables: Wn = 0.97u; Wp = 0.58u; W2 = 11u; I1 = 6.1m; I2 = 4.1m; Ws = 0.4u; C2 = 0; I = 3.1m; W1 = 15u; Ws1 = 1*Ws; Ws2 = 2*Ws; Ws3 = 3*Ws; Ws5 = 5*Ws; Ws6 = 6*Ws; Ws4 = 4*Ws
  Temperature: 85.0
  Simulator options: additionalArgs=vdsatmod=gds
  Analysis tran: stop=10n errpreset=moderate noisefmax=300G outputstart=1n
  Output freq(VT("/Va1") "rising" ?xName "time" ?mode "auto" ?threshold 0.6)
  Signals: /Va1, /K0/s1 (terminal) as Iscd, /Va2, /K0/p1 (terminal) as Iprm
Run mode: Single Run, Sweeps and Corners
Global variables:
  I1 = 20m
  I2 = 0.005m
Corners (all switched off):
  model folders: $SPECTRE_MODEL_PATH
  NOM_85: temperature=85; design_wrapper_mmw.lib.scs[tt_pre]
  SLOW_m40 (off): temperature=-40; design_wrapper_mmw.lib.scs[ss_pre]
  SLOW_125 (off): temperature=125; design_wrapper_mmw.lib.scs[ss_pre]
  FAST_m40 (off): temperature=-40; design_wrapper_mmw.lib.scs[ff_pre]
  FAST_125 (off): temperature=125; design_wrapper_mmw.lib.scs[ff_pre]
