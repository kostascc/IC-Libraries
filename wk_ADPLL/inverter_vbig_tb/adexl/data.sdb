ADE simulation setup
Run mode: Single Run, Sweeps and Corners
Tests:
  wk_ADPLL:inverter_vbig_tb:1: wk_ADPLL/inverter_vbig_tb/schematic, simulator spectre
    Outputs: Tr; Tf
Global variables:
  CL = 3f
  tf = 0.1
  tr = 0.1
  VDD = 0.8
  VSS = 0
  freqD = 45G
Corners:
  model folders: $SPECTRE_MODEL_PATH
  FF_PRE: design_wrapper.lib.scs[ff_pre]
  FS_PRE: design_wrapper.lib.scs[fs_pre]
  SF_PRE: design_wrapper.lib.scs[sf_pre]
  SS_PRE: design_wrapper.lib.scs[ff_pre]
  FF_POST (off): design_wrapper.lib.scs[ff_post]
  FS_POST (off): design_wrapper.lib.scs[fs_post]
  SF_POST (off): design_wrapper.lib.scs[sf_post]
  SS_POST (off): design_wrapper.lib.scs[ff_post]
