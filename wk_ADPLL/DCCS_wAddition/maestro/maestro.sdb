ADE simulation setup
Run mode: Single Run, Sweeps and Corners
Tests:
  T1: wk_ADPLL/DCCS_wAddition/schematic, simulator spectre
    Variables: R = 1K; Wref = 2u; H = 0.8; L = 0; s1 = L; s2 = L
    Outputs: average(VT("/R0/PLUS)")); average(Iref); average(VT("/Iref")) [A]; avgIref [A]; /Vs1; /Vs2; /N0/d; /Iref; CornerDiffAvgIref [A]; avgVref [V]; CornerAvgIref; CornerDiffAvgIrefPercent [%]
Global variables:
  s1 = H
  s2 = L
  s3 = L
  Wref = 1u
  R = 200
  I = 1.5m
  Mref = 1
  Lref = 40n
  NFref = 8
  Msw = 1
  Lsw = 20n
  Mmrr = 1
  Lmrr = 20n
  NFmrr1 = 8
  NFmrr2 = 8
  NFmrr3 = 16
  NFsw1 = NFmrr1
  NFsw2 = NFmrr2
  NFsw3 = NFmrr3
Corners (nominal off):
  model folders: $SPECTRE_MODEL_PATH
  TT_85 (off): temperature=85; design_wrapper_mmw.lib.scs[tt_pre]
  TT_125 (off): temperature=125; design_wrapper_mmw.lib.scs[tt_pre]
  SS_m40 (off): temperature=-40; design_wrapper_mmw.lib.scs[ss_pre]
  SS_125: temperature=125; design_wrapper_mmw.lib.scs[ss_pre]
  FF_m40: temperature=-40; design_wrapper_mmw.lib.scs[ff_pre]
  FF_125 (off): temperature=125; design_wrapper_mmw.lib.scs[ff_pre]
