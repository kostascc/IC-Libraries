ADE simulation setup
Test T1: wk_ADPLL/DCCS_wAddition/schematic, simulator spectre
  Models: $SPECTRE_MODEL_PATH/design_wrapper.lib.scs[tt_pre]
  Variables: R = 1K; Wref = 2u; H = 0.8; L = 0; s1 = L; s2 = L
  Temperature: 27
  Simulator options: additionalArgs=vdsatmod=gds
  Stimulus VSS: voltage dc dc=0
  Stimulus VDD: voltage dc dc=0.8
  Stimulus Vs2: voltage dc dc=s2
  Stimulus Vs1: voltage dc dc=s1
  Stimulus Vs3: voltage dc dc=s3
  Analysis dc: (saves the operating point)
  Analysis tran: stop=2n errpreset=moderate outputstart=0.2n
  Output avgIref = average(IT("/R0/PLUS"))
  Output CornerDiffAvgIref = (ymax(avgIref ?overall t) - ymin(avgIref ?overall t))
  Output avgVref = average(VT("/Iref"))
  Output CornerAvgIref = average(avgIref ?overall t)
  Output CornerDiffAvgIrefPercent = (100 * (CornerDiffAvgIref / CornerAvgIref))
  Signals: /R0/PLUS (terminal), /Iref
Run mode: Single Run, Sweeps and Corners
Global variables:
  s1 = H
  s2 = L
  s3 = L
  Wref = 1u
  R = 200
  I = 1.5m
  Mref = 1
  Lref = 40n
  NFref = 8
  Msw = 1
  Lsw = 20n
  Mmrr = 1
  Lmrr = 20n
  NFmrr1 = 8
  NFmrr2 = 8
  NFmrr3 = 16
  NFsw1 = NFmrr1
  NFsw2 = NFmrr2
  NFsw3 = NFmrr3
Corners (nominal off):
  model folders: $SPECTRE_MODEL_PATH
  TT_85 (off): temperature=85; design_wrapper_mmw.lib.scs[tt_pre]
  TT_125 (off): temperature=125; design_wrapper_mmw.lib.scs[tt_pre]
  SS_m40 (off): temperature=-40; design_wrapper_mmw.lib.scs[ss_pre]
  SS_125: temperature=125; design_wrapper_mmw.lib.scs[ss_pre]
  FF_m40: temperature=-40; design_wrapper_mmw.lib.scs[ff_pre]
  FF_125 (off): temperature=125; design_wrapper_mmw.lib.scs[ff_pre]
