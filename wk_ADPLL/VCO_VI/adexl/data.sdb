ADE simulation setup
Run mode: Single Run, Sweeps and Corners
Tests:
  wk_ADPLL:VCO_VI:1: wk_ADPLL/VCO_VI/schematic, simulator spectre
Global variables:
  I = 3m 4m
  NA = 1
  W1 = 13u
  Ws1 = 0.4u
  Ws2 = 400n
  Ws3 = 400n
  Ws4 = 400n
  Ws5 = 400n
  Ws6 = 400n
