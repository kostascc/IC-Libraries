ADE simulation setup
Test Steady_State: wk_ADPLL/VCO_VI/schematic, simulator spectre
  Models: $SPECTRE_MODEL_PATH/design_wrapper_mmw.lib.scs[tt_pre]
  Variables: M1 = 2; Wss = 150n; C = 1; I = 2m; NA = 0; W1 = 13u; Ws = 200n; Ws1 = 1*Ws; Ws2 = 2*Ws; Ws3 = 4*Ws; Ws4 = 8*Ws; Ws5 = 16*Ws; Ws6 = 32*Ws
  Temperature: 27
  Simulator options: additionalArgs=vdsatmod=gds
  Stimulus S1: voltage dc dc=S1
  Stimulus Vsw6: voltage dc dc=B6
  Stimulus Vsw5: voltage dc dc=B5
  Stimulus Vsw4: voltage dc dc=B4
  Stimulus Vsw3: voltage dc dc=B3
  Stimulus Vsw2: voltage dc dc=B2
  Stimulus Vsw1: voltage dc dc=B1
  Stimulus Vbb: voltage dc dc=Vbb
  Stimulus Vb: voltage dc dc=Vb
  Stimulus Vbbb: voltage dc dc=Vbbb
  Initial conditions: /Va2 = 0.8; /Va1 = 0.8
  Analysis tran: stop=15n errpreset=moderate noisefmax=300G outputstart=0.5n
  Analysis pss: engine=Harmonic Balance fund=56G harms=7 oscana=t p=/Va1 n=/Va2 errpreset=moderate
  Analysis pnoise: start=1M stop=100M fund=56G p=/Va1 n=/Va2 relharmnum=1 noisetype=timeaverage
  Output freqVa1 = freq(VT("/Va1") "rising" ?xName "time" ?mode "auto" ?threshold 0.8)
  Output avgCornerFreqVa1 = average(freqVa1 ?overall t)
  Output diffAvgFreqVa1 = (ymax(avgFreqVa1 ?overall t) - ymin(avgFreqVa1 ?overall t))
  Output VppVa1 = peakToPeak(VT("/Va1"))
  Output diffFreqVa1 = (ymax(freqVa1) - ymin(freqVa1))
  Output OutNoise = rfOutputNoise("dBc/Hz" ?result "pnoise")
  Output PhaseNoise_1M = value(OutNoise 1000000.0)
  Output PhaseNoise_10M = value(OutNoise 1e+07)
  Output avgFreqVa1 = average(freqVa1)
  Signals: /Va1, /Vref
Test Time_Sweep: wk_ADPLL/VCO_VI/schematic, simulator spectre
  Models: $SPECTRE_MODEL_PATH/design_wrapper_mmw.lib.scs[tt_pre]
  Variables: Wss = 150n; C = 1; I = 2m; NA = 0; W1 = 13u; Ws = 200n; Ws1 = 1*Ws; Ws2 = 2*Ws; Ws3 = 4*Ws; Ws4 = 8*Ws; Ws5 = 16*Ws; Ws6 = 32*Ws
  Temperature: 27
  Simulator options: additionalArgs=vdsatmod=gds
  Stimulus S1: voltage dc dc=S1
  Stimulus Vsw6: voltage pulse val0=0 val1=800.0m period=160n rise=1p fall=1p
  Stimulus Vsw5: voltage pulse val0=0 val1=800.0m period=80n rise=1p fall=1p
  Stimulus Vsw4: voltage pulse val0=0 val1=800.0m period=40n rise=1p fall=1p
  Stimulus Vsw3: voltage pulse val0=0 val1=800.0m period=20n rise=1p fall=1p
  Stimulus Vsw2: voltage pulse val0=0 val1=800.0m period=10n rise=1p fall=1p
  Stimulus Vsw1: voltage pulse val0=0 val1=800.0m period=5n rise=1p fall=1p
  Stimulus Vb: voltage dc dc=Vb
  Analysis tran: stop=40n errpreset=moderate noisefmax=300G outputstart=1n
  Output freqVa1 = freq(VT("/Va1") "rising" ?xName "time" ?mode "auto" ?threshold 0.8)
  Output avgCornerFreqVa1 = average(freqVa1 ?overall t)
  Output diffAvgFreqVa1 = (ymax(avgFreqVa1 ?overall t) - ymin(avgFreqVa1 ?overall t))
  Output VppVa1 = peakToPeak(VT("/Va1"))
  Output diffFreqVa1 = (ymax(freqVa1) - ymin(freqVa1))
  Output OutNoise = rfOutputNoise("dBc/Hz" ?result "pnoise") (unticked)
  Output PhaseNoise_1M = value(OutNoise 1000000.0) (unticked)
  Output PhaseNoise_10M = value(OutNoise 1e+07) (unticked)
  Output avgFreqVa1 = average(freqVa1)
  Signals: /Va1
