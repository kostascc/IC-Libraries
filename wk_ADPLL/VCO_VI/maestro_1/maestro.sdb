ADE simulation setup
Run mode: Single Run, Sweeps and Corners
Tests:
  Steady_State: wk_ADPLL/VCO_VI/schematic, simulator spectre
    Variables: I = 2m; NA = 0; W1 = 13u; Ws1 = 1*Ws; Ws2 = 2*Ws; Ws3 = 4*Ws; Ws4 = 8*Ws; Ws5 = 16*Ws; Ws6 = 32*Ws; Ws = 200n; C = 1; Wss = 150n; M1 = 2
    Outputs: /Va1; /Va2; freq(VT("/Va1") "rising" ?xName "time" ?mode "auto" ?threshold 0.6); average(freq(VT("/Va1") "rising" ?xName "time" ?mode "auto" ?threshold 0.8)); freqVa1; average(VT("/freqVa1")); avgCornerFreqVa1; ymax(?overall t); diffAvgFreqVa1; VppVa1; diffFreqVa1; OutNoise [dBc/Hz]; PhaseNoise_1M [dBc/Hz]; PhaseNoise_10M [dBc/Hz]; avgFreqVa1
  Time_Sweep (off): wk_ADPLL/VCO_VI/schematic, simulator spectre
    Variables: Wss = 150n; C = 1; I = 2m; NA = 0; W1 = 13u; Ws = 200n; Ws1 = 1*Ws; Ws2 = 2*Ws; Ws3 = 4*Ws; Ws4 = 8*Ws; Ws5 = 16*Ws; Ws6 = 32*Ws
    Outputs: /Va1; /Va2; freq(VT("/Va1") "rising" ?xName "time" ?mode "auto" ?threshold 0.6); average(freq(VT("/Va1") "rising" ?xName "time" ?mode "auto" ?threshold 0.8)); freqVa1; average(VT("/freqVa1")); avgCornerFreqVa1; ymax(?overall t); diffAvgFreqVa1; VppVa1; diffFreqVa1; OutNoise [dBc/Hz]; PhaseNoise_1M [dBc/Hz]; PhaseNoise_10M [dBc/Hz]; avgFreqVa1
Global variables:
  Ws = 270n
  W1 = 1u:0.1u:2u
  M1 = 3
  Ms = 110
  C = 1
  I = 6.1m
  Wss = L (off)
  Vb = H
  S1 = L H
  B3 = L
  B1 = L
  B2 = L
  B4 = L
  B6 = L
  B5 = L
  H = 0.8
  L = 0
  Vbbb = 0.8
  Vbb = 0.8
  W2 = 1
  W3 = 4
  Ls = 20n
  L1 = 20n
  Lref = 20n
Device parameters (all switched off):
  wk_ADPLL/VCO_VI/schematic/N0.w = 13u 15u (off)
Corners:
  model folders: $SPECTRE_MODEL_PATH
  TT_85 (off): temperature=85; design_wrapper_mmw.lib.scs[tt_pre]
  TT_125 (off): temperature=125; design_wrapper_mmw.lib.scs[tt_pre]
  SS_m40 (off): temperature=-40; design_wrapper_mmw.lib.scs[ss_pre]
  SS_125 (off): temperature=125; design_wrapper_mmw.lib.scs[ss_pre]
  FF_m40 (off): temperature=-40; design_wrapper_mmw.lib.scs[ff_pre]
  FF_125 (off): temperature=125; design_wrapper_mmw.lib.scs[ff_pre]
Specs:
  Steady_State / diffAvgFreqVa1: min 4G
  Steady_State / VppVa1: range 0.4 to 1.2
  Steady_State / diffFreqVa1: range 0 to 100M
  Steady_State / PhaseNoise_1M: < -90
  Steady_State / PhaseNoise_10M: < -110
  Steady_State / avgCornerFreqVa1: range 46G to 66G
  Time_Sweep / diffAvgFreqVa1: min 1
  Time_Sweep / VppVa1: range 0.4 to 1.2
  Time_Sweep / diffFreqVa1: range 0 to 100M
  Time_Sweep / avgCornerFreqVa1: range 46G to 66G
