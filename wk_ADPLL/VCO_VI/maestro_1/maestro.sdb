ADE simulation setup
Run mode: Single Run, Sweeps and Corners
Tests:
  Steady_State (off): wk_ADPLL/VCO_VI/schematic, simulator spectre
    Variables: I = 2m; NA = 0; W1 = 13u; Ws1 = 1*Ws; Ws2 = 2*Ws; Ws3 = 4*Ws; Ws4 = 8*Ws; Ws5 = 16*Ws; Ws6 = 32*Ws; Ws = 200n; C = 1; Wss = 150n
    Outputs: /Va1; /Va2; freq(VT("/Va1") "rising" ?xName "time" ?mode "auto" ?threshold 0.6); average(freq(VT("/Va1") "rising" ?xName "time" ?mode "auto" ?threshold 0.8)); freqVa1; average(VT("/freqVa1")); avgCornerFreqVa1; ymax(?overall t); diffAvgFreqVa1; VppVa1; diffFreqVa1; OutNoise [dBc/Hz]; PhaseNoise_1M [dBc/Hz]; PhaseNoise_10M [dBc/Hz]; avgFreqVa1
  Time_Sweep: wk_ADPLL/VCO_VI/schematic, simulator spectre
    Variables: Wss = 150n; C = 1; I = 2m; NA = 0; W1 = 13u; Ws = 200n; Ws1 = 1*Ws; Ws2 = 2*Ws; Ws3 = 4*Ws; Ws4 = 8*Ws; Ws5 = 16*Ws; Ws6 = 32*Ws
    Outputs: /Va1; /Va2; freq(VT("/Va1") "rising" ?xName "time" ?mode "auto" ?threshold 0.6); average(freq(VT("/Va1") "rising" ?xName "time" ?mode "auto" ?threshold 0.8)); freqVa1; average(VT("/freqVa1")); avgCornerFreqVa1; ymax(?overall t); diffAvgFreqVa1; VppVa1; diffFreqVa1; OutNoise [dBc/Hz]; PhaseNoise_1M [dBc/Hz]; PhaseNoise_10M [dBc/Hz]; avgFreqVa1
Global variables:
  Ws = 150n 180n
  W1 = 9u
  C = 35
  I = 2.1m 2.6m 3.1m 3.7m
  Wss = 150n (off)
  S1 = L
  B1 = L H (off)
  B2 = L H (off)
  B3 = L H (off)
  B4 = L H (off)
  B5 = L H (off)
  B6 = L H (off)
  H = 0.8
  L = 0
Device parameters (all switched off):
  wk_ADPLL/VCO_VI/schematic/N0.w = 13u 15u (off)
Corners:
  model folders: $SPECTRE_MODEL_PATH
  TT_85: temperature=85; design_wrapper_mmw.lib.scs[tt_pre]
  TT_125: temperature=125; design_wrapper_mmw.lib.scs[tt_pre]
  SS_m40: temperature=-40; design_wrapper_mmw.lib.scs[ss_pre]
  SS_125: temperature=125; design_wrapper_mmw.lib.scs[ss_pre]
  FF_m40: temperature=-40; design_wrapper_mmw.lib.scs[ff_pre]
  FF_125: temperature=125; design_wrapper_mmw.lib.scs[ff_pre]
Specs:
  Steady_State / diffAvgFreqVa1: min 1
  Steady_State / VppVa1: range 0.4 to 1.2
  Steady_State / diffFreqVa1: range 0 to 100M
  Steady_State / PhaseNoise_1M: > -90
  Steady_State / PhaseNoise_10M: < -105
  Steady_State / avgCornerFreqVa1: range 46G to 66G
  Time_Sweep / diffAvgFreqVa1: min 1
  Time_Sweep / VppVa1: range 0.4 to 1.2
  Time_Sweep / diffFreqVa1: range 0 to 100M
  Time_Sweep / PhaseNoise_1M: > -90
  Time_Sweep / PhaseNoise_10M: < -105
  Time_Sweep / avgCornerFreqVa1: range 46G to 66G
