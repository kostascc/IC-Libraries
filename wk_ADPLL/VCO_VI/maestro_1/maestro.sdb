ADE simulation setup
Run mode: Single Run, Sweeps and Corners
Tests:
  wk_ADPLL:VCO_VI:1: wk_ADPLL/VCO_VI/schematic, simulator spectre
    Variables: I = 2m; NA = 0; W1 = 13u; Ws1 = 1*Ws; Ws2 = 2*Ws; Ws3 = 4*Ws; Ws4 = 8*Ws; Ws5 = 16*Ws; Ws6 = 32*Ws; Ws = 400n; C = 1; Ws7 = 400n
    Outputs: /Va1; /Va2; freq(VT("/Va1") "rising" ?xName "time" ?mode "auto" ?threshold 0.6); /Vsw1; /Vsw2; /Vsw3; /Vsw4; /Vsw5; /Vsw6
  wk_ADPLL:VCO_VI:2 (off): wk_ADPLL/VCO_VI/schematic, simulator spectre
Global variables:
  Ws = 0.4u
  W1 = 15u
Device parameters (all switched off):
  wk_ADPLL/VCO_VI/schematic/N0.w = 13u 15u (off)
Corners (nominal off):
  model folders: $SPECTRE_MODEL_PATH
  NOM_85: temperature=85; design_wrapper_mmw.lib.scs[tt_pre]
  SLOW_m40 (off): temperature=-40; design_wrapper_mmw.lib.scs[ss_pre]
  SLOW_125 (off): temperature=125; design_wrapper_mmw.lib.scs[ss_pre]
  FAST_m40 (off): temperature=-40; design_wrapper_mmw.lib.scs[ff_pre]
  FAST_125 (off): temperature=125; design_wrapper_mmw.lib.scs[ff_pre]
Specs:
  wk_ADPLL:VCO_VI:1 / freq(VT("/Va1") "rising" ?xName "time" ?mode "auto" ?threshold 0.6): min 1
