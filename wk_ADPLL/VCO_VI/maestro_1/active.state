ADE simulation setup
Test wk_ADPLL:VCO_VI:2: wk_ADPLL/VCO_VI/schematic, simulator spectre
  Models: $SPECTRE_MODEL_PATH/design_wrapper.lib.scs[tt_pre]
  Temperature: 27
  Simulator options: additionalArgs=vdsatmod=gds
  Analysis acmatch: start=1M stop=1G p=/Va1 n=/VSS skipdc=no
Test wk_ADPLL:VCO_VI:1: wk_ADPLL/VCO_VI/schematic, simulator spectre
  Models: $SPECTRE_MODEL_PATH/design_wrapper_mmw.lib.scs[tt_pre]
  Variables: C = 1; Ws7 = 400n; I = 2m; NA = 0; W1 = 13u; Ws = 400n; Ws1 = 1*Ws; Ws2 = 2*Ws; Ws3 = 4*Ws; Ws4 = 8*Ws; Ws5 = 16*Ws; Ws6 = 32*Ws
  Temperature: 27
  Simulator options: additionalArgs=vdsatmod=gds
  Analysis tran: stop=160n errpreset=moderate noisefmax=300G outputstart=1n
  Output freq(VT("/Va1") "rising" ?xName "time" ?mode "auto" ?threshold 0.6)
  Signals: /Va1, /Va2, /Vsw1, /Vsw2, /Vsw3, /Vsw4, /Vsw5, /Vsw6
