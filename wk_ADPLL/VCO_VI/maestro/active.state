ADE simulation setup
Test wk_ADPLL:VCO_VI:1: wk_ADPLL/VCO_VI/schematic, simulator spectre
  Models: $SPECTRE_MODEL_PATH/design_wrapper_mmw.lib.scs[tt_pre]
  Variables: I = 2.9m; NA = 1; W1 = 18u; Ws = 200n; Ws1 = 1*Ws; Ws2 = 1*Ws; Ws3 = 1*Ws; Ws4 = 1*Ws; Ws5 = 1*Ws; Ws6 = 1*Ws; Ws7 = 1*Ws
  Temperature: 27
  Simulator options: additionalArgs=vdsatmod=gds
  Initial conditions: /Va2 = 1; /Va1 = 0.4
  Analysis tran: stop=320n errpreset=moderate noisefmax=200G outputstart=1n
  Output F1 = freq(VT("/Va1") "rising" ?xName "time" ?mode "auto" ?threshold 0.8)
  Output F2 = freq(VT("/Va2") "rising" ?xName "time" ?mode "auto" ?threshold 0.8)
  Signals: /Va1, /Va2, /Vsw1, /Vsw2, /Vsw3, /Vsw4, /Vsw5, /Vsw6, /Vsw7
Run mode: Single Run, Sweeps and Corners
Global variables:
  I = 2.9m 3.1m
  NA = 1
  W1 = 18u
  Ws = 200n
  Ws1 = 1*Ws
  Ws2 = 1*Ws
  Ws3 = 1*Ws
  Ws4 = 1*Ws
  Ws5 = 1*Ws
  Ws6 = 1*Ws
  Ws7 = 1*Ws
