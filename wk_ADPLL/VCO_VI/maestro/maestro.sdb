ADE simulation setup
Run mode: Single Run, Sweeps and Corners
Tests:
  wk_ADPLL:VCO_VI:1: wk_ADPLL/VCO_VI/schematic, simulator spectre
    Variables: I = 2.9m; NA = 1; W1 = 18u; Ws = 200n; Ws1 = 1*Ws; Ws2 = 1*Ws; Ws3 = 1*Ws; Ws4 = 1*Ws; Ws5 = 1*Ws; Ws6 = 1*Ws; Ws7 = 1*Ws
Global variables:
  I = 2.9m 3.1m
  NA = 1
  W1 = 18u
  Ws = 200n
  Ws1 = 1*Ws
  Ws2 = 1*Ws
  Ws3 = 1*Ws
  Ws4 = 1*Ws
  Ws5 = 1*Ws
  Ws6 = 1*Ws
  Ws7 = 1*Ws
