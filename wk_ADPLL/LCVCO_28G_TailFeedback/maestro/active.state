ADE simulation setup
Test Steady_State: wk_ADPLL/LCVCO_28G_TailFeedback/schematic, simulator spectre
  Models: $SPECTRE_MODEL_PATH/design_wrapper_mmw.lib.scs[tt_pre]
  Variables: Cb = 2f; Cfb = 2f; Rb = 30; M1 = 2; Wss = 150n; C = 1; I = 2m; NA = 0; W1 = 13u; Ws = 200n; Ws1 = 1*Ws; Ws2 = 2*Ws; Ws3 = 4*Ws; Ws4 = 8*Ws; Ws5 = 16*Ws; Ws6 = 32*Ws
  Temperature: 27
  Simulator options: additionalArgs=vdsatmod=gds
  Stimulus S1: voltage dc dc=S1
  Stimulus Vsw6: voltage dc dc=B6
  Stimulus Vsw5: voltage dc dc=B5
  Stimulus Vsw4: voltage dc dc=B4
  Stimulus Vsw3: voltage dc dc=B3
  Stimulus Vsw2: voltage dc dc=B2
  Stimulus Vsw1: voltage dc dc=B1
  Stimulus Vbb: voltage dc dc=Vbb
  Stimulus Vb: voltage dc dc=Vb
  Stimulus Vbbb: voltage dc dc=Vbbb
  Analysis tran: stop=15n errpreset=moderate noisefmax=300G outputstart=0.5n
  Analysis pss: engine=Harmonic Balance fund=28G harms=7 oscana=t p=/Vop n=/Von errpreset=moderate
  Analysis pnoise: start=1K stop=10M fund=28G p=/Vop n=/Von relharmnum=1 noisetype=timeaverage
  Output Vo = (VT("/Vop") - VT("/Von"))
  Output freqVo = freq(Vo "rising" ?xName "time" ?mode "auto" ?threshold 0)
  Output avgCornerFreqVo = average(freqVo ?overall t)
  Output avgFreqVo = average(freqVo)
  Output diffAvgFreqVo = (ymax(avgFreqVo ?overall t) - ymin(avgFreqVo ?overall t))
  Output VppVo = peakToPeak(Vo)
  Output diffFreqVo = (ymax(freqVo) - ymin(freqVo))
  Output OutNoise = rfOutputNoise("dBc/Hz" ?result "pnoise")
  Output PhaseNoise_1M = value(OutNoise 1000000.0)
  Output PhaseNoise_10M = value(OutNoise 1e+07)
  Output VrefPeak = ymax(VT("/Vref"))
  Signals: /Vop, /Von, /Vref
Run mode: Single Run, Sweeps and Corners
Global variables:
  Ws = 270n
  W1 = 22
  C = 130
  M1 = 2
  S1 = L
  Ms = 8
  I = 3.2m
  Wss = L (off)
  Vb = H
  B3 = L
  B1 = L
  B2 = L
  B4 = L
  B6 = L
  B5 = L
  H = 0.8
  L = 0
  Vbbb = 0.8
  Vbb = 0.8
  W2 = 1
  W3 = 4
  Ls = 20n
  L1 = 20n
  Lref = 35n
  Cfb = 2f
  Cb = 2f
  Rb = 4
  LT = 118p
Device parameters (all switched off):
  wk_ADPLL/VCO_VI/schematic/N0.w = 13u 15u (off)
Corners (all switched off):
  model folders: $SPECTRE_MODEL_PATH
  TT_85: temperature=85; design_wrapper_mmw.lib.scs[tt_pre]
  TT_125 (off): temperature=125; design_wrapper_mmw.lib.scs[tt_pre]
  SS_m40: temperature=-40; design_wrapper_mmw.lib.scs[ss_pre]
  SS_125: temperature=125; design_wrapper_mmw.lib.scs[ss_pre]
  FF_m40: temperature=-40; design_wrapper_mmw.lib.scs[ff_pre]
  FF_125: temperature=125; design_wrapper_mmw.lib.scs[ff_pre]
Specs:
  Steady_State / diffAvgFreqVo: min 4G
  Steady_State / VppVo: range 0.4 to 1.2
  Steady_State / diffFreqVo: range 0 to 100M
  Steady_State / PhaseNoise_1M: < -90
  Steady_State / PhaseNoise_10M: < -110
  Steady_State / avgCornerFreqVo: range 18G to 38G
Disabled tests: Time_Sweep, wk_ADPLL:VCO_VI:1, wk_ADPLL:VCO_VI:2
