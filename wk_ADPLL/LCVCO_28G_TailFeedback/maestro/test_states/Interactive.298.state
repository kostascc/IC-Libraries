ADE simulation setup
Test Steady_State: wk_ADPLL/LCVCO_28G_TailFeedback/schematic, simulator spectre
  Models: $SPECTRE_MODEL_PATH/design_wrapper_mmw.lib.scs[tt_pre]
  Variables: Cb = 2f; Cfb = 2f; Rb = 30; M1 = 2; Wss = 150n; C = 1; I = 2m; NA = 0; W1 = 13u; Ws = 200n; Ws1 = 1*Ws; Ws2 = 2*Ws; Ws3 = 4*Ws; Ws4 = 8*Ws; Ws5 = 16*Ws; Ws6 = 32*Ws
  Temperature: 27
  Simulator options: additionalArgs=vdsatmod=gds
  Stimulus S1: voltage dc dc=S1
  Stimulus Vsw6: voltage dc dc=B6
  Stimulus Vsw5: voltage dc dc=B5
  Stimulus Vsw4: voltage dc dc=B4
  Stimulus Vsw3: voltage dc dc=B3
  Stimulus Vsw2: voltage dc dc=B2
  Stimulus Vsw1: voltage dc dc=B1
  Stimulus Vbb: voltage dc dc=Vbb
  Stimulus Vb: voltage dc dc=Vb
  Stimulus Vbbb: voltage dc dc=Vbbb
  Analysis pss: engine=Harmonic Balance fund=28G harms=7 oscana=t p=/Vop n=/Von errpreset=moderate
  Analysis pnoise: start=1K stop=10M fund=28G p=/Vop n=/Von relharmnum=1 noisetype=timeaverage
  Analysis tran: stop=15n errpreset=moderate noisefmax=300G outputstart=0.5n
  Output Vo = (VT("/Vop") - VT("/Von"))
  Output freqVo = freq(Vo "rising" ?xName "time" ?mode "auto" ?threshold 0)
  Output avgCornerFreqVo = average(freqVo ?overall t)
  Output avgFreqVo = average(freqVo)
  Output diffAvgFreqVo = (ymax(avgFreqVo ?overall t) - ymin(avgFreqVo ?overall t))
  Output VppVo = peakToPeak(Vo)
  Output diffFreqVo = (ymax(freqVo) - ymin(freqVo))
  Output OutNoise = rfOutputNoise("dBc/Hz" ?result "pnoise")
  Output PhaseNoise_1M = value(OutNoise 1000000.0)
  Output PhaseNoise_10M = value(OutNoise 1e+07)
  Output VrefPeak = ymax(VT("/Vref"))
  Signals: /Vop, /Von, /Vref
