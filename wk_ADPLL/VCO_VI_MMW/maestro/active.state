ADE simulation setup
Test Steady_State: wk_ADPLL/VCO_VI_MMW/schematic, simulator spectre
  Models: $SPECTRE_MODEL_PATH/design_wrapper_mmw.lib.scs[tt_pre]
  Variables: Wss = 150n; C = 1; I = 2m; NA = 0; W1 = 13u; Ws = 200n; Ws1 = 1*Ws; Ws2 = 2*Ws; Ws3 = 4*Ws; Ws4 = 8*Ws; Ws5 = 16*Ws; Ws6 = 32*Ws
  Temperature: 27
  Simulator options: additionalArgs=vdsatmod=gds
  Stimulus S1: voltage dc dc=S1
  Stimulus Vsw6: voltage dc dc=B6
  Stimulus Vsw5: voltage dc dc=B5
  Stimulus Vsw4: voltage dc dc=B4
  Stimulus Vsw3: voltage dc dc=B3
  Stimulus Vsw2: voltage dc dc=B2
  Stimulus Vsw1: voltage dc dc=B1
  Analysis tran: stop=13n errpreset=moderate noisefmax=300G outputstart=1n
  Analysis pss: engine=Harmonic Balance fund=28G harms=7 oscana=t p=/Va1 n=/Va2 errpreset=moderate
  Analysis pnoise: start=1M stop=100M fund=28G p=/Va1 n=/Va2 relharmnum=1 noisetype=timeaverage
  Output freqVa1 = freq(VT("/Va1") "rising" ?xName "time" ?mode "auto" ?threshold 0.8)
  Output avgCornerFreqVa1 = average(freqVa1 ?overall t)
  Output diffAvgFreqVa1 = (ymax(avgFreqVa1 ?overall t) - ymin(avgFreqVa1 ?overall t))
  Output VppVa1 = peakToPeak(VT("/Va1"))
  Output diffFreqVa1 = (ymax(freqVa1) - ymin(freqVa1))
  Output OutNoise = rfOutputNoise("dBc/Hz" ?result "pnoise") (unticked)
  Output PhaseNoise_1M = value(OutNoise 1000000.0)
  Output PhaseNoise_10M = value(OutNoise 1e+07)
  Output avgFreqVa1 = average(freqVa1)
  Signals: /Va1
Test Time_Sweep: wk_ADPLL/VCO_VI_MMW/schematic, simulator spectre
  Models: $SPECTRE_MODEL_PATH/design_wrapper_mmw.lib.scs[tt_pre]
  Variables: Wss = 150n; C = 1; I = 2m; NA = 0; W1 = 13u; Ws = 200n; Ws1 = 1*Ws; Ws2 = 2*Ws; Ws3 = 4*Ws; Ws4 = 8*Ws; Ws5 = 16*Ws; Ws6 = 32*Ws
  Temperature: 27
  Simulator options: additionalArgs=vdsatmod=gds
  Stimulus S1: voltage dc dc=S1
  Stimulus Vsw6: voltage pulse val0=0 val1=0.8 period=160n rise=1p fall=1p
  Stimulus Vsw5: voltage pulse val0=0 val1=0.8 period=80n rise=1p fall=1p
  Stimulus Vsw4: voltage pulse val0=0 val1=0.8 period=40n rise=1p fall=1p
  Stimulus Vsw3: voltage pulse val0=0 val1=0.8 period=20n rise=1p fall=1p
  Stimulus Vsw2: voltage pulse val0=0 val1=0.8 period=10n rise=1p fall=1p
  Stimulus Vsw1: voltage sin sinedc=0.8 ampl=0.8 freq=1/10n filenums=none
  Analysis tran: stop=10n errpreset=moderate noisefmax=300G outputstart=1n
  Output freqVa1 = freq(VT("/Va1") "rising" ?xName "time" ?mode "auto" ?threshold 0.8)
  Output avgCornerFreqVa1 = average(freqVa1 ?overall t)
  Output diffAvgFreqVa1 = (ymax(avgFreqVa1 ?overall t) - ymin(avgFreqVa1 ?overall t))
  Output VppVa1 = peakToPeak(VT("/Va1"))
  Output diffFreqVa1 = (ymax(freqVa1) - ymin(freqVa1))
  Output OutNoise = rfOutputNoise("dBc/Hz" ?result "pnoise") (unticked)
  Output PhaseNoise_1M = value(OutNoise 1000000.0) (unticked)
  Output PhaseNoise_10M = value(OutNoise 10000000.0) (unticked)
  Output avgFreqVa1 = average(freqVa1)
  Signals: /Va1, /Vsw1 as Vsw1
Run mode: Single Run, Sweeps and Corners
Global variables:
  Ws = 600n
  W1 = 8u
  C = 35
  I = 2.2m
  Wss = 150n (off)
  S1 = L
  B1 = L H (off)
  B2 = L H (off)
  B3 = L H (off)
  B4 = L H (off)
  B5 = L H (off)
  B6 = L H (off)
  H = 0.8
  L = 0
Device parameters (all switched off):
  wk_ADPLL/VCO_VI/schematic/N0.w = 13u 15u (off)
Corners (nominal off):
  model folders: $SPECTRE_MODEL_PATH
  TT_85: temperature=85; design_wrapper_mmw.lib.scs[tt_pre]
  TT_125 (off): temperature=125; design_wrapper_mmw.lib.scs[tt_pre]
  SS_m40: temperature=-40; design_wrapper_mmw.lib.scs[ss_pre]
  SS_125: temperature=125; design_wrapper_mmw.lib.scs[ss_pre]
  FF_m40: temperature=-40; design_wrapper_mmw.lib.scs[ff_pre]
  FF_125: temperature=125; design_wrapper_mmw.lib.scs[ff_pre]
Specs:
  Steady_State / diffAvgFreqVa1: min 4G
  Steady_State / VppVa1: range 0.4 to 1.2
  Steady_State / diffFreqVa1: range 0 to 100M
  Steady_State / PhaseNoise_1M: > -90
  Steady_State / PhaseNoise_10M: < -105
  Steady_State / avgCornerFreqVa1: range 46G to 66G
  Time_Sweep / diffAvgFreqVa1: min 1
  Time_Sweep / VppVa1: range 0.4 to 1.2
  Time_Sweep / diffFreqVa1: range 7G to 13G
  Time_Sweep / avgCornerFreqVa1: range 46G to 66G
Disabled tests: Steady_State, wk_ADPLL:VCO_VI:1, wk_ADPLL:VCO_VI:2
