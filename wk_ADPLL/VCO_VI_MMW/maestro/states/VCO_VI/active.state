ADE simulation setup
Test Steady_State: wk_ADPLL/VCO_VI/schematic, simulator spectre
  Models: $SPECTRE_MODEL_PATH/design_wrapper_mmw.lib.scs[tt_pre]
  Variables: Wss = 150n; C = 1; I = 2m; NA = 0; W1 = 13u; Ws = 200n; Ws1 = 1*Ws; Ws2 = 2*Ws; Ws3 = 4*Ws; Ws4 = 8*Ws; Ws5 = 16*Ws; Ws6 = 32*Ws
  Temperature: 27
  Simulator options: additionalArgs=vdsatmod=gds
  Stimulus S1: voltage dc dc=S1
  Stimulus Vsw6: voltage dc dc=B6
  Stimulus Vsw5: voltage dc dc=B5
  Stimulus Vsw4: voltage dc dc=B4
  Stimulus Vsw3: voltage dc dc=B3
  Stimulus Vsw2: voltage dc dc=B2
  Stimulus Vsw1: voltage dc dc=B1
  Analysis tran: stop=4n errpreset=moderate noisefmax=300G outputstart=1n
  Analysis pnoise: start=1M stop=100M fund=28G p=/Va1 n=/Va2 relharmnum=1 noisetype=timeaverage
  Analysis pss: engine=Harmonic Balance fund=28G harms=7 oscana=t p=/Va1 n=/Va2 errpreset=moderate
  Output freqVa1 = freq(VT("/Va1") "rising" ?xName "time" ?mode "auto" ?threshold 0.8)
  Output avgFreqVa1 = average(freqVa1)
  Output diffAvgFreqVa1 = (ymax(avgFreqVa1 ?overall t) - ymin(avgFreqVa1 ?overall t))
  Output VppVa1 = peakToPeak(VT("/Va1"))
  Output diffFreqVa1 = (ymax(freqVa1) - ymin(freqVa1))
  Output OutNoise = rfOutputNoise("dBc/Hz" ?result "pnoise")
  Output PhaseNoise_1M = value(OutNoise 1000000.0)
  Output PhaseNoise_10M = value(OutNoise 1e+07)
  Signals: /Va1
Test wk_ADPLL:VCO_VI:2: wk_ADPLL/VCO_VI/schematic, simulator spectre
  Models: $SPECTRE_MODEL_PATH/design_wrapper.lib.scs[tt_pre]
  Temperature: 27
  Simulator options: additionalArgs=vdsatmod=gds
  Analysis acmatch: start=1M stop=1G p=/Va1 n=/VSS skipdc=no
