ADE simulation setup
Run mode: Single Run, Sweeps and Corners
Tests:
  KC:transmission_gate_tb:1: KC/transmission_gate_tb/schematic, simulator spectre
    Outputs: Tr-Tf; Wp; (var); Wn
Global variables:
  Wp = 200n:100n:1.3u
  Wn = 150n:100n:750n
  Vinss = 0
  Vindd = 1.2
  VSS = 0
  VDD = 1.2
  Tep = 0.000001
  F2 = 1M
  F = 56G
  CL = 1.5f
