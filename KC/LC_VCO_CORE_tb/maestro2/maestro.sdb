ADE simulation setup
Run mode: Single Run, Sweeps and Corners
Global variables:
  T_STOP = 60n
  VDD = 0.9
  ibias = 300u
  nfinga = 20
  COARSE_TRIM_CAP = 1
  FINE_TRIM_CAP = 1
  wireopt = 19
  VCTRL = 0.1:0.02:0.7
  CONFIG/wk_ADPLL/LC_VCO_CORE = schematic_egcaps schematic_ncaps schematic_ncaps_big (off)
  ilo = 2800u
  iloF = 28G
  mult = 1:1:10 (off)
Corners (nominal off):
  model folders: $SPECTRE_MODEL_PATH
  NOM_85: temperature=85; design_wrapper_mmw.lib.scs[tt_pre]
  SLOW_m40 (off): temperature=-40; design_wrapper_mmw.lib.scs[ss_pre]
  SLOW_125 (off): temperature=125; design_wrapper_mmw.lib.scs[ss_pre]
  FAST_m40 (off): temperature=-40; design_wrapper_mmw.lib.scs[ff_pre]
  FAST_125 (off): temperature=125; design_wrapper_mmw.lib.scs[ff_pre]
