ADE simulation setup
Test wk_ADPLL:DCO_CORE_tb:1: wk_ADPLL/LC_VCO_CORE_tb/config_schematic, simulator spectre
  Models: $SPECTRE_MODEL_PATH/design_wrapper.lib.scs[tt_pre]
  Variables: mult = 1; VCTRL = 0.4; fclk = 10M
  Temperature: 27
  Simulator options: additionalArgs=vdsatmod=gds
  Initial conditions: /VP = 0.45
  Analysis tran: stop=VAR("T_STOP")
  Analysis pnoise: start=1 stop=100M fund=28G p=/VP n=/VN relharmnum=1 noisetype=timeaverage
  Analysis pss: engine=Harmonic Balance fund=28G harms=7 tstab=12n oscana=t p=/VP n=/VN
  Output VT("/VP")
  Output VT("/VN")
  Output VAMP_SE = (ymax(clip(VT("/VP") 4e-08 VAR("T_STOP"))) - ymin(clip(VT("/VP") 4e-08 VAR("T_STOP"))))
  Output VCM = ((0.5 * VAMP_SE) + ymin(clip(VT("/VP") 4e-08 VAR("T_STOP"))))
  Output FOSC = average(freq(clip((VT("/VP") - VT("/VN")) 4e-08 VAR("T_STOP")) "rising" ?xName "time" ?mode "auto" ?threshold 0.0))
  Output output noise; dBc/Hz = rfOutputNoise("dBc/Hz" ?result "pnoise")
  Output PN_1M = value(rfOutputNoise("dBc/Hz" ?result "pnoise") 1000000.0)
  Output PN_10M = value(rfOutputNoise("dBc/Hz" ?result "pnoise") 1e+07)
  Output FOSC1 = average(freq(clip((VT("/VP1") - VT("/VN1")) 4e-08 VAR("T_STOP")) "rising" ?xName "time" ?mode "auto" ?threshold 0.0))
  Signals: /VP, /VN, /VP1, /VN1
