ADE simulation setup
Test wk_ADPLL:DCO_CORE_tb:1: wk_ADPLL/DCO_CORE_tb/config_schematic, simulator spectre
  Models: $SPECTRE_MODEL_PATH/design_wrapper.lib.scs[tt_pre]
  Variables: fclk = 28G; wireopt = 19
  Temperature: 27
  Simulator options: additionalArgs=vdsatmod=gds
  Initial conditions: /VP = 0.3
  Analysis pss: engine=Harmonic Balance fund=28G harms=7 oscana=t p=/VP n=/VN
  Analysis tran: stop=160n
  Analysis pnoise: start=1 stop=100M fund=28G p=/VP n=/VN maxsideband=10 noisetype=sampled
  Output FREQUENCY = frequency(VT("/VP"))
  Output PWR = average(IT("/I0/VDD"))
  Output VOSCpp_SE = (ymax(clip(VT("/VP") 8e-08 1.8e-07)) - ymin(clip(VT("/VP") 8e-08 1.8e-07)))
  Output output noise; dBc/Hz = rfOutputNoise("dBc/Hz" ?result "pnoise")
  Output PN = rfEdgePhaseNoise(?result "pnoise_sample_pm0" ?eventList 'nil)
  Output VCM_output = (ymin(VT("/VP")) + (0.5 * (ymax(VT("/VP")) - ymin(VT("/VP")))))
  Output PN_1M = value(rfEdgePhaseNoise(?result "pnoise_sample_pm0" ?eventList 'nil) 1000000.0)
  Output PN_10M = value(rfEdgePhaseNoise(?result "pnoise_sample_pm0" ?eventList 'nil) 1e+07)
  Signals: /VP, /VN, /I0/N2/d (terminal), /SET<8:1>, /I0/VDD (terminal)
