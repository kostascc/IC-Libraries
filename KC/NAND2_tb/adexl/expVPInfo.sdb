ADE simulation setup
Global variables:
  F = 10G
  CL = 7f
  VDD = 800m
  VSS = 0
  N = 13
  WpWn = 1
  Wn = N*100n
  Wp = WpWn*Wn
