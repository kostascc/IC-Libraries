ADE simulation setup
Run mode: Single Run, Sweeps and Corners
Tests:
  KC:NAND2_tb:1: KC/NAND2_tb/schematic, simulator spectre
Global variables:
  F = 10G
  CL = 7f
  VDD = 800m
  VSS = 0
  N = 13
  WpWn = 1
  Wn = N*100n
  Wp = WpWn*Wn
Corners:
  model folders: $SPECTRE_MODEL_PATH
  FF_PRE: design_wrapper.lib.scs[ff_pre]
  FS_PRE: design_wrapper.lib.scs[fs_pre]
  SF_PRE: design_wrapper.lib.scs[sf_pre]
  SS_PRE: design_wrapper.lib.scs[ff_pre]
  FF_POST (off): design_wrapper.lib.scs[ff_post]
  FS_POST (off): design_wrapper.lib.scs[fs_post]
  SF_POST (off): design_wrapper.lib.scs[sf_post]
  SS_POST (off): design_wrapper.lib.scs[ff_post]
