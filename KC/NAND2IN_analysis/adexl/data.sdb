ADE simulation setup
Run mode: Single Run, Sweeps and Corners
Tests:
  myLib:NAND2IN_analysis:1: myLib/NAND2IN_analysis/schematic, simulator spectre
  myLib:NAND2IN_analysis:1:1 (off): myLib/NAND2IN_analysis/schematic, simulator spectre
  myLib:NAND2IN_analysis:1:1:1 (off): myLib/NAND2IN_analysis/schematic, simulator spectre
  myLib:NAND2IN_analysis:4 (off): myLib/NAND2IN_analysis/schematic, simulator spectre
  myLib:NAND2IN_analysis:2 (off): myLib/NAND2IN_analysis/schematic, simulator spectre
  myLib:NAND2IN_analysis:3 (off): myLib/NAND2IN_analysis/schematic, simulator spectre
Global variables:
  T = 0.1n
  wireopt = 11
  nl = 20n
  nw = 190n
  pl = 20n
  pw = 150n
  nfing = 1
  pfing = 1
  NW2 = 400n
  PW2 = 320n
  NW = 1e-07
  PW = 1e-07
  PW1 = 275n
  C = 5f
  F = 5G
  NL = 20n
  PL = 20n
Corners (all switched off):
  model folders: $SPECTRE_MODEL_PATH
  FF: design_wrapper.lib.scs[ff_post]; not for myLib:NAND2IN_analysis:4
  SS: design_wrapper.lib.scs[ss_post]; not for myLib:NAND2IN_analysis:4
  SF: design_wrapper.lib.scs[sf_post]; not for myLib:NAND2IN_analysis:4
  FS: design_wrapper.lib.scs[fs_post]; not for myLib:NAND2IN_analysis:4
