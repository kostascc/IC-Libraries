ADE simulation setup
Global variables:
  T = 0.1n
  wireopt = 11
  nl = 20n
  nw = 190n
  pl = 20n
  pw = 150n
  nfing = 1
  pfing = 1
  NW2 = 400n
  PW2 = 320n
  NW = 1e-07
  PW = 1e-07
  PW1 = 275n
  C = 5f
  F = 5G
  NL = 20n
  PL = 20n
