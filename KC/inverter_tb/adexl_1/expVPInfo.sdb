ADE simulation setup
Global variables:
  CL = 5f
  F = 10G
  VDD = 0.8
  VSS = 0
  WpWn = 1.7215
  Wn = 570n
  Wp = WpWn*Wn
