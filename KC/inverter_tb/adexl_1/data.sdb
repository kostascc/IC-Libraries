ADE simulation setup
Run mode: Single Run, Sweeps and Corners
Tests:
  KC:inverter_tb:1: KC/inverter_tb/schematic, simulator spectre
    Outputs: Tpd
Global variables:
  CL = 5f
  F = 10G
  VDD = 0.8
  VSS = 0
  WpWn = 1.7215
  Wn = 570n
  Wp = WpWn*Wn
Corners:
  model folders: $SPECTRE_MODEL_PATH
  FF_PRE: design_wrapper.lib.scs[ff_pre]
  FS_PRE: design_wrapper.lib.scs[fs_pre]
  SF_PRE: design_wrapper.lib.scs[sf_pre]
  SS_PRE: design_wrapper.lib.scs[ff_pre]
  FF_POST (off): design_wrapper.lib.scs[ff_post]
  FS_POST (off): design_wrapper.lib.scs[fs_post]
  SF_POST (off): design_wrapper.lib.scs[sf_post]
  SS_POST (off): design_wrapper.lib.scs[ff_post]
Single Run, Sweeps and Corners options: submitpointsenabled=0
